ADE simulation setup
Test PROJECT_MIXER:kalem:1: PROJECT_MIXER/kalem_STD_TEST/schematic, simulator spectre
  Models: /home/work/RF_26/TSMC65GP_22/tsmcN65/../models/spectre/crn65gplus_2d5_lk_v1d0.scs[tt_bip, tt_dio, tt_dio_33, tt_mim, tt_dio_dnw, tt_dio_18, tt_bip_npn, tt_33, tt_rfrtmom, tt_mos_cap_25, tt_18, tt_disres, tt_res, tt_dio_na, tt_rfmos_33, tt_dio_hvt, tt_rfmvar, tt_rfmos_18, tt_na, tt_dio_na33, tt_dio_lvt, tt_rfres_sa, tt_na33, tt_dio_esd, tt_rfmim, tt_dio_25od33, tt_25od33, tt, tt_mos_cap, tt_dio_25, tt_dio_25ud18, tt_25, tt_rfmos, tt_25ud18, tt_dio_na25od33, tt_rfjvar, tt_rfmos_25, tt_rtmom, tt_na25od33, tt_dio_na25, tt_rfres_rpo, tt_hvt, tt_rfind, tt_rfmvar_25, tt_na25, tt_lvt]
  Temperature: 27
  Analysis sp: start=1G stop=60G step=0.5G ports=("/PORT0")
  Output Z11 magOhm = zpm('sp 1 1)
  Output Rs = real(zpm('sp 1 1))
  Output Ls = imag(real(zpm('sp 1 1)))
  Output Q = (imag(real(zpm('sp 1 1))) / real(real(zpm('sp 1 1))))
  Output (imag(real(zpm('sp 1 1))) / (2 * pi * xval(zpm('sp 1 1))))
Run mode: Single Run, Sweeps and Corners

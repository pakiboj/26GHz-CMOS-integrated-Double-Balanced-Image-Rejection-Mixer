ADE simulation setup
Test PROJECT_MIXER:NMOS_RF:1:1: PROJECT_MIXER/NMOS_RF/schematic, simulator spectre
  Models: /home/work/RF_26/TSMC65GP_22/tsmcN65/../models/spectre/crn65gplus_2d5_lk_v1d0.scs[tt_bip, tt_dio, tt_dio_33, tt_mim, tt_dio_dnw, tt_dio_18, tt_bip_npn, tt_33, tt_rfrtmom, tt_mos_cap_25, tt_18, tt_disres, tt_res, tt_dio_na, tt_rfmos_33, tt_dio_hvt, tt_rfmvar, tt_rfmos_18, tt_na, tt_dio_na33, tt_dio_lvt, tt_rfres_sa, tt_na33, tt_dio_esd, tt_rfmim, tt_dio_25od33, tt_25od33, tt, tt_mos_cap, tt_dio_25, tt_dio_25ud18, tt_25, tt_rfmos, tt_25ud18, tt_dio_na25od33, tt_rfjvar, tt_rfmos_25, tt_rtmom, tt_na25od33, tt_dio_na25, tt_rfres_rpo, tt_hvt, tt_rfind, tt_rfmvar_25, tt_na25, tt_lvt]
  Variables: L = 140n; nf = 1; VBS = 0; VDS = 0.2; VGS = 0.7; W = 1u
  Temperature: 27
  Operating points saved: /NMOS_RF (cdg cdd cdb vdsat vth gm ids)
  Analysis dc: sweep VGS start=0 stop=1.2 step=5m (saves the operating point)
  Output ID = OP("/NMOS_RF" "ids")
  Output JD = (OP("/NMOS_RF" "ids") / VAR("W"))
  Output GM = OP("/NMOS_RF" "gm")
  Output gmID = (OP("/NMOS_RF" "gm") / OP("/NMOS_RF" "ids"))
  Output vth = OP("/NMOS_RF" "vth")
  Output VDsat = OP("/NMOS_RF" "vdsat")
  Output cdd = OP("/NMOS_RF" "cdd")
  Output cdb = OP("/NMOS_RF" "cdb")
  Output cdg = OP("/NMOS_RF" "cdg")
  Output VOV = (VAR("VGS") - OP("/NMOS_RF" "vth"))
  Output JDs = (OS("/NMOS_RF" "ids") / VAR("W")) (unticked)
  Output IDs = OS("/NMOS_RF" "ids") (unticked)
  Output GMs = OS("/NMOS_RF" "gm")
  Output gmIDs = (OS("/NMOS_RF" "gm") / OS("/NMOS_RF" "ids")) (unticked)
  Output vths = OS("/NMOS_RF" "vth") (unticked)
  Output VDsats = OS("/NMOS_RF" "vdsat") (unticked)
  Output cdds = OS("/NMOS_RF" "cdd") (unticked)
  Output vdbs = OS("/NMOS_RF" "cdb") (unticked)
  Output cdgs = OS("/NMOS_RF" "cdg") (unticked)
  Output VOVs = (VAR("VGS") - OS("/NMOS_RF" "vth")) (unticked)

ADE simulation setup
Run mode: Single Run, Sweeps and Corners
Tests:
  sweep: PROJECT_MIXER/NMOS_RF/schematic, simulator spectre
    Variables: L = 65n; nf = 40; VBS = 0; VDS = 0.32; VGS = 0; W = 1u
    Outputs: JD; VOV; (OS("/NMOS_RF" "ids") / (pv "W")); (OS("/NMOS_RF" "ids") / ((pv / NMOS_RF) "W")); (pv "/NMOS_RF"); IDs; (OS("/NMOS_RF" "ids") - VAR("W")); JDs; 5; VOVs

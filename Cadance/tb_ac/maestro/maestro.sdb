ADE simulation setup
Run mode: Single Run, Sweeps and Corners
Tests:
  PROJECT_MIXER:tb_ac:1: PROJECT_MIXER/tb_ac/schematic, simulator spectre
    Variables: flo = 26G; L = 150p; Llo = 65n; Lrf = 140n; nflo = 62; nfrf = 40; pacmag = 1; plo = 10; RL = 404; VDD = 1.2; Wlo = 1u; Wrf = 1u; C = 0
    Outputs: v /net2; ac mag(V)

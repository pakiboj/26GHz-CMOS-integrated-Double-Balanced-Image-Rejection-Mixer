ADE simulation setup
Test PROJECT_MIXER:tb_ac:1: PROJECT_MIXER/tb_ac/schematic, simulator spectre
  Models: /home/work/RF_26/TSMC65GP_22/tsmcN65/../models/spectre/crn65gplus_2d5_lk_v1d0.scs[tt_bip, tt_dio, tt_dio_33, tt_mim, tt_dio_dnw, tt_dio_18, tt_bip_npn, tt_33, tt_rfrtmom, tt_mos_cap_25, tt_18, tt_disres, tt_res, tt_dio_na, tt_rfmos_33, tt_dio_hvt, tt_rfmvar, tt_rfmos_18, tt_na, tt_dio_na33, tt_dio_lvt, tt_rfres_sa, tt_na33, tt_dio_esd, tt_rfmim, tt_dio_25od33, tt_25od33, tt, tt_mos_cap, tt_dio_25, tt_dio_25ud18, tt_25, tt_rfmos, tt_25ud18, tt_dio_na25od33, tt_rfjvar, tt_rfmos_25, tt_rtmom, tt_na25od33, tt_dio_na25, tt_rfres_rpo, tt_hvt, tt_rfind, tt_rfmvar_25, tt_na25, tt_lvt]
  Variables: C = 0; flo = 26G; plo = 10; RL = 404; VDD = 1.2; L = 150p; Wlo = 1u; Wrf = 1u; Llo = 65n; Lrf = 140n; nflo = 62; nfrf = 40; pacmag = 1
  Temperature: 27
  Analysis ac: start=1k stop=30G
  Output v /net2; ac mag(V) = (vfreq('ac "/net2") - vfreq('ac "/net02"))
  Output v /net02; ac mag(V) = vfreq('ac "/net02")
  Output v /net18; ac mag(V) = vfreq('ac "/net18")
Run mode: Single Run, Sweeps and Corners

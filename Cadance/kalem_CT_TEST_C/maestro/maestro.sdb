ADE simulation setup
Run mode: Single Run, Sweeps and Corners
Tests:
  PROJECT_MIXER:kalem:1: PROJECT_MIXER/kalem_TEST_C/schematic, simulator spectre

ADE simulation setup
Test S: PROJECT_MIXER/tb_real_LAYOUT_S_param/schematic, simulator spectre
  Models: /home/work/RF_26/TSMC65GP_22/tsmcN65/../models/spectre/crn65gplus_2d5_lk_v1d0.scs[tt_bip, tt_dio, tt_dio_33, tt_mim, tt_dio_dnw, tt_dio_18, tt_bip_npn, tt_33, tt_rfrtmom, tt_mos_cap_25, tt_18, tt_disres, tt_res, tt_dio_na, tt_rfmos_33, tt_dio_hvt, tt_rfmvar, tt_rfmos_18, tt_na, tt_dio_na33, tt_dio_lvt, tt_rfres_sa, tt_na33, tt_dio_esd, tt_rfmim, tt_dio_25od33, tt_25od33, tt, tt_mos_cap, tt_dio_25, tt_dio_25ud18, tt_25, tt_rfmos, tt_25ud18, tt_dio_na25od33, tt_rfjvar, tt_rfmos_25, tt_rtmom, tt_na25od33, tt_dio_na25, tt_rfres_rpo, tt_hvt, tt_rfind, tt_rfmvar_25, tt_na25, tt_lvt]
  Variables: Vbb = 650m; Vlo = 700m; L = 149.5p; plo = 10; prf = -30; Llo = 65n; Lrf = 65n; nflo = 62; nfrf = 40; RL = 404; VDD = 1.2; Wlo = 1u; Wrf = 1u; flo = 26G; frf = 400M; pacmag = 1; C = 0
  Temperature: 27
  Analysis psp: start=15G stop=30G ports=[/PORT5]
  Analysis pss: engine=Shooting fund=26G harms=8
  Output Z11 magOhm = zpm('psp 1 1) (unticked)
  Output Real Z = real(zpm('psp 1 1))
  Output Imag Z = (imag(zpm('psp 1 1)) / (2 * pi * xval(zpm('psp 1 1)))) (unticked)
  Output Y11 magS = ypm('psp 1 1) (unticked)
  Output Imag Y = (imag(ypm('psp 1 1)) / (2 * pi * xval(zpm('psp 1 1)))) (unticked)
Test dc: PROJECT_MIXER/tb_ideal_S_param/schematic, simulator spectre
  Models: /home/work/RF_26/TSMC65GP_22/tsmcN65/../models/spectre/crn65gplus_2d5_lk_v1d0.scs[tt_bip, tt_dio, tt_dio_33, tt_mim, tt_dio_dnw, tt_dio_18, tt_bip_npn, tt_33, tt_rfrtmom, tt_mos_cap_25, tt_18, tt_disres, tt_res, tt_dio_na, tt_rfmos_33, tt_dio_hvt, tt_rfmvar, tt_rfmos_18, tt_na, tt_dio_na33, tt_dio_lvt, tt_rfres_sa, tt_na33, tt_dio_esd, tt_rfmim, tt_dio_25od33, tt_25od33, tt, tt_mos_cap, tt_dio_25, tt_dio_25ud18, tt_25, tt_rfmos, tt_25ud18, tt_dio_na25od33, tt_rfjvar, tt_rfmos_25, tt_rtmom, tt_na25od33, tt_dio_na25, tt_rfres_rpo, tt_hvt, tt_rfind, tt_rfmvar_25, tt_na25, tt_lvt]
  Variables: C = 0; flo = 26G; Vlo = 700; Wlo = 1u; Wrf = 1u; L = 150p; Llo = 65n; Lrf = 140n; nflo = 62; nfrf = 40; pacmag = 1; plo = 10; RL = 404; Vbb = 410; VDD = 1.2
  Temperature: 27
  Analysis dc: (saves the operating point)
Run mode: Single Run, Sweeps and Corners

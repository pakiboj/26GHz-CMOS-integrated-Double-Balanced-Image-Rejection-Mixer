ADE simulation setup
Test sweep: PROJECT_MIXER/NMOS_LO/schematic, simulator spectre
  Models: /home/work/RF_26/TSMC65GP_22/tsmcN65/../models/spectre/crn65gplus_2d5_lk_v1d0.scs[tt_bip, tt_dio, tt_dio_33, tt_mim, tt_dio_dnw, tt_dio_18, tt_bip_npn, tt_33, tt_rfrtmom, tt_mos_cap_25, tt_18, tt_disres, tt_res, tt_dio_na, tt_rfmos_33, tt_dio_hvt, tt_rfmvar, tt_rfmos_18, tt_na, tt_dio_na33, tt_dio_lvt, tt_rfres_sa, tt_na33, tt_dio_esd, tt_rfmim, tt_dio_25od33, tt_25od33, tt, tt_mos_cap, tt_dio_25, tt_dio_25ud18, tt_25, tt_rfmos, tt_25ud18, tt_dio_na25od33, tt_rfjvar, tt_rfmos_25, tt_rtmom, tt_na25od33, tt_dio_na25, tt_rfres_rpo, tt_hvt, tt_rfind, tt_rfmvar_25, tt_na25, tt_lvt]
  Variables: VG = 0; VS = 0.32; L = 65n; nf = 2; W = 1u
  Temperature: 27
  Operating points saved: /NMOS_LO (gds vgs vth cdd vdsat gm ids)
  Analysis dc: sweep VG start=0.7 stop=1 step=5m (saves the operating point)
  Output ID = OP("/NMOS_LO" "ids")
  Output JD = (OP("/NMOS_LO" "ids") / (VAR("W") * VAR("nf")))
  Output VDsat = OP("/NMOS_LO" "vdsat")
  Output cdd = OP("/NMOS_LO" "cdd")
  Output vdbs = OS("/NMOS_LO" "cdb") (unticked)
  Output cdb = OP("/NMOS_LO" "cdb")
  Output VOV = (OP("/NMOS_LO" "vgs") - OP("/NMOS_LO" "vth"))
  Output cdgs = OS("/NMOS_LO" "cdg") (unticked)
  Output IDs = OS("/NMOS_LO" "ids")
  Output value(OP("/NMOS_LO" "region") 0.1)
  Output GMs = OS("/NMOS_LO" "gm")
  Output gmIDs = (OS("/NMOS_LO" "gm") / OS("/NMOS_LO" "ids")) (unticked)
  Output value(OP("/NMOS_LO" "region") 0.5)
  Output vths = OS("/NMOS_LO" "vth")
  Output cdds = OS("/NMOS_LO" "cdd")
  Output value(OP("/NMOS_LO" "region") 1.1)
  Output (1 / OP("/NMOS_LO" "gds"))
  Output gmID = (OP("/NMOS_LO" "gm") / OP("/NMOS_LO" "ids"))
  Output r0 = (1 / OS("/NMOS_LO" "gds"))
  Output VOVs = (OS("/NMOS_LO" "vgs") - OS("/NMOS_LO" "vth"))
  Output GM = OP("/NMOS_LO" "gm")
  Output value(OP("/NMOS_LO" "region") 0.3)
  Output cdg = OP("/NMOS_LO" "cdg")
  Output value(OP("/NMOS_LO" "region") 0.7)
  Output VOVscale = ((OS("/NMOS_LO" "vgs") - OS("/NMOS_LO" "vth")) / 1.41) (unticked)
  Output value(OP("/NMOS_LO" "region") 0.9)
  Output CDD = value(OS("/NMOS_LO" "cdd") 0.88)
  Output JDs = (OS("/NMOS_LO" "ids") / (VAR("W") * VAR("nf")))
  Output vth = OP("/NMOS_LO" "vth")
  Output VDsats = OS("/NMOS_LO" "vdsat") (unticked)
Run mode: Single Run, Sweeps and Corners

ADE simulation setup
Run mode: Single Run, Sweeps and Corners
Tests:
  sweep: PROJECT_MIXER/NMOS_LO/schematic, simulator spectre
    Variables: L = 65n; nf = 2; W = 1u; VG = 0; VS = 0.32
    Outputs: JD; VOV; (OS("/NMOS_RF" "ids") / (pv "W")); (OS("/NMOS_RF" "ids") / ((pv / NMOS_RF) "W")); (pv "/NMOS_RF"); IDs; (OS("/NMOS_RF" "ids") - VAR("W")); JDs; VOVs; ID; GM; gmID; vth; VDsat; cdd; cdb; cdg; GMs; gmIDs; vths; VDsats; cdds; vdbs; cdgs; value(OP("/NMOS_LO" "region") 0.1); value(OP("/NMOS_LO" "region") 0.3); value(OP("/NMOS_LO" "region") 0.5); value(OP("/NMOS_LO" "region") 0.7); value(OP("/NMOS_LO" "region") 0.9); value(OP("/NMOS_LO" "region") 1.1); CDD; value(OS("/NMOS_LO" "vth") 0.88); (1.41 * ((VAR("VGS") - OS("/NMOS_LO" "vth")))); VOVscale

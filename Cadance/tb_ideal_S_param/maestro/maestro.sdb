ADE simulation setup
Run mode: Single Run, Sweeps and Corners
Tests:
  S: PROJECT_MIXER/tb_ideal_S_param/schematic, simulator spectre
    Variables: L = 149.5p; Llo = 65n; VDD = 1.2; Wlo = 1u; Wrf = 1u; flo = 26G; frf = 400M; pacmag = 1; plo = 10; prf = -30; Lrf = 65n; nflo = 62; nfrf = 40; RL = 404; C = 0; Vbb = 650m; Vlo = 700m
  dc: PROJECT_MIXER/tb_ideal_S_param/schematic, simulator spectre
    Variables: C = 0; flo = 26G; L = 150p; Llo = 65n; Lrf = 140n; nflo = 62; nfrf = 40; pacmag = 1; plo = 10; RL = 404; Vbb = 410; VDD = 1.2; Vlo = 700; Wlo = 1u; Wrf = 1u

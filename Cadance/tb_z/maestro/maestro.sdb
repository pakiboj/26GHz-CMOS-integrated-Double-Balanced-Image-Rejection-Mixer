ADE simulation setup
Run mode: Single Run, Sweeps and Corners
Tests:
  PROJECT_MIXER:tb_z:1: PROJECT_MIXER/tb_z/schematic, simulator spectre
    Variables: C = 206.1f; L = 178p; R = 484

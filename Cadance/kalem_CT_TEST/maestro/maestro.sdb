ADE simulation setup
Run mode: Single Run, Sweeps and Corners
Tests:
  PROJECT_MIXER:kalem:1: PROJECT_MIXER/kalem_CT_TEST/schematic, simulator spectre
    Outputs: L11

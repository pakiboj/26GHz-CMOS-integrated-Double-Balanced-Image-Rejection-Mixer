ADE simulation setup
Test pac:1:1: PROJECT_MIXER/tb_real/schematic, simulator spectre
  Models: /home/work/RF_26/TSMC65GP_22/tsmcN65/../models/spectre/crn65gplus_2d5_lk_v1d0.scs[tt_bip, tt_dio, tt_dio_33, tt_mim, tt_dio_dnw, tt_dio_18, tt_bip_npn, tt_33, tt_rfrtmom, tt_mos_cap_25, tt_18, tt_disres, tt_res, tt_dio_na, tt_rfmos_33, tt_dio_hvt, tt_rfmvar, tt_rfmos_18, tt_na, tt_dio_na33, tt_dio_lvt, tt_rfres_sa, tt_na33, tt_dio_esd, tt_rfmim, tt_dio_25od33, tt_25od33, tt, tt_mos_cap, tt_dio_25, tt_dio_25ud18, tt_25, tt_rfmos, tt_25ud18, tt_dio_na25od33, tt_rfjvar, tt_rfmos_25, tt_rtmom, tt_na25od33, tt_dio_na25, tt_rfres_rpo, tt_hvt, tt_rfind, tt_rfmvar_25, tt_na25, tt_lvt]
  Variables: VBB = 650m; VLO = 700m; prf = -30; RL = 404; VDD = 1.2; Wlo = 1u; Wrf = 1u; frf = 0; L = 150p; Llo = 65n; Lrf = 65n; nflo = 62; nfrf = 40; pacmag = 1; plo = 10; C = 0; flo = 26G
  Temperature: 27
  Analysis pac: start=400M stop=28G fund=26G sweeptype=absolute
  Analysis pss: engine=Shooting fund=26G harms=10
  Output ((/net02 /net2))/((/net18 /net16) h=0) pac dB20(V/V) = db(((vh('pac "/net02") - vh('pac "/net2")) / harmonic((vh('pac "/net18") - vh('pac "/net16")) '(0))))

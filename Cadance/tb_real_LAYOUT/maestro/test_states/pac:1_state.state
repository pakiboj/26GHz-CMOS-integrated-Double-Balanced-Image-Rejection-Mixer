ADE simulation setup
Test pac:1: MIXER_project/tb/schematic, simulator spectre
  Models: /home/work/RF_26/TSMC65GP_22/tsmcN65/../models/spectre/crn65gplus_2d5_lk_v1d0.scs[tt_bip, tt_dio, tt_dio_33, tt_mim, tt_dio_dnw, tt_dio_18, tt_bip_npn, tt_33, tt_rfrtmom, tt_mos_cap_25, tt_18, tt_disres, tt_res, tt_dio_na, tt_rfmos_33, tt_dio_hvt, tt_rfmvar, tt_rfmos_18, tt_na, tt_dio_na33, tt_dio_lvt, tt_rfres_sa, tt_na33, tt_dio_esd, tt_rfmim, tt_dio_25od33, tt_25od33, tt, tt_mos_cap, tt_dio_25, tt_dio_25ud18, tt_25, tt_rfmos, tt_25ud18, tt_dio_na25od33, tt_rfjvar, tt_rfmos_25, tt_rtmom, tt_na25od33, tt_dio_na25, tt_rfres_rpo, tt_hvt, tt_rfind, tt_rfmvar_25, tt_na25, tt_lvt]
  Variables: flo = 5.6G; frf = 0; pacmag = 1; plo = 10; prf = -30
  Temperature: 27
  Analysis pss: sweep plo start=-10 stop=15 sweepStep=1 engine=Shooting fund=5.6G harms=10
  Analysis pac: start=5.601G fund=5.6G sweeptype=absolute
  Output (/net3 h=-1)/(/net5 h=0)  pac dB20(V/V) = db((vh('pac "/net3" '-1) / vh('pac "/net5" '(0))))
  Output (/net2 h=-1)/(/gnd! h=0)  pac dB20(V/V) = db(0)

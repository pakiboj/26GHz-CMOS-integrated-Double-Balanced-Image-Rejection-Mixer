ADE simulation setup
Test qpss:1: PROJECT_MIXER/tb_real/schematic, simulator spectre
  Models: /home/work/RF_26/TSMC65GP_22/tsmcN65/../models/spectre/crn65gplus_2d5_lk_v1d0.scs[tt_bip, tt_dio, tt_dio_33, tt_mim, tt_dio_dnw, tt_dio_18, tt_bip_npn, tt_33, tt_rfrtmom, tt_mos_cap_25, tt_18, tt_disres, tt_res, tt_dio_na, tt_rfmos_33, tt_dio_hvt, tt_rfmvar, tt_rfmos_18, tt_na, tt_dio_na33, tt_dio_lvt, tt_rfres_sa, tt_na33, tt_dio_esd, tt_rfmim, tt_dio_25od33, tt_25od33, tt, tt_mos_cap, tt_dio_25, tt_dio_25ud18, tt_25, tt_rfmos, tt_25ud18, tt_dio_na25od33, tt_rfjvar, tt_rfmos_25, tt_rtmom, tt_na25od33, tt_dio_na25, tt_rfres_rpo, tt_hvt, tt_rfind, tt_rfmvar_25, tt_na25, tt_lvt]
  Variables: flo = 26G; frf = 400M; VDD = 1.2; VLO = 800m; Wlo = 1u; Wrf = 1u; Llo = 65n; Lrf = 65n; nflo = 62; nfrf = 40; pacmag = 1; plo = 10; prf = -30; VBB = 650m
  Temperature: 27
  Analysis qpss: sweep frf start=5.60000001G stop=5.8G lin=100 engine=Shooting funds=("FLO" "RF") maxharms=("7" "3")
  Analysis qpnoise: start=26G stop=27G oprobe=/PORT5 iprobe=/PORT1 refsideband=("-1" "0")
  Output ((/net2 /net3) h=-1,1)/((/net5 /gnd!) h=0,1) qpss dB20(V/V) = db(((vh('qpss "/net2" '((-1 1))) - vh('qpss "/net3" '((-1 1)))) / vh('qpss "/net5" '((0 1)))))

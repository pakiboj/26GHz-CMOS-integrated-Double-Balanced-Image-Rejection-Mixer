ADE simulation setup
Test pss_sweep: PROJECT_MIXER/tb_real_LAYOUT/schematic, simulator spectre
  Models: /home/work/RF_26/TSMC65GP_22/tsmcN65/../models/spectre/crn65gplus_2d5_lk_v1d0.scs[tt_bip, tt_dio, tt_dio_33, tt_mim, tt_dio_dnw, tt_dio_18, tt_bip_npn, tt_33, tt_rfrtmom, tt_mos_cap_25, tt_18, tt_disres, tt_res, tt_dio_na, tt_rfmos_33, tt_dio_hvt, tt_rfmvar, tt_rfmos_18, tt_na, tt_dio_na33, tt_dio_lvt, tt_rfres_sa, tt_na33, tt_dio_esd, tt_rfmim, tt_dio_25od33, tt_25od33, tt, tt_mos_cap, tt_dio_25, tt_dio_25ud18, tt_25, tt_rfmos, tt_25ud18, tt_dio_na25od33, tt_rfjvar, tt_rfmos_25, tt_rtmom, tt_na25od33, tt_dio_na25, tt_rfres_rpo, tt_hvt, tt_rfind, tt_rfmvar_25, tt_na25, tt_lvt]
  Variables: frf2 = 0; prf2 = 0; nfrf = 40; pacmag = 1; plo = 10; C = 0; flo = 26G; prf = -30; RL = 404; VDD = 1.2; Wlo = 1u; VBB = 650m; VLO = 700m; Wrf = 1u; frf = 0; L = 150p; Llo = 65n; Lrf = 65n; nflo = 62
  Temperature: 27
  Analysis pss: sweep plo start=-10 stop=15 sweepStep=1 engine=Shooting fund=26G harms=10
  Output ((/net2 /net02) h=1)/((/net16 /net18) h=0) pac dB20(V/V) = db(((vh('pac "/net2" '(1)) - vh('pac "/net02" '(1))) / (vh('pac "/net16" '(0)) - vh('pac "/net18" '(0)))))
Test pac: PROJECT_MIXER/tb_real_LAYOUT/schematic, simulator spectre
  Models: /home/work/RF_26/TSMC65GP_22/tsmcN65/../models/spectre/crn65gplus_2d5_lk_v1d0.scs[tt_bip, tt_dio, tt_dio_33, tt_mim, tt_dio_dnw, tt_dio_18, tt_bip_npn, tt_33, tt_rfrtmom, tt_mos_cap_25, tt_18, tt_disres, tt_res, tt_dio_na, tt_rfmos_33, tt_dio_hvt, tt_rfmvar, tt_rfmos_18, tt_na, tt_dio_na33, tt_dio_lvt, tt_rfres_sa, tt_na33, tt_dio_esd, tt_rfmim, tt_dio_25od33, tt_25od33, tt, tt_mos_cap, tt_dio_25, tt_dio_25ud18, tt_25, tt_rfmos, tt_25ud18, tt_dio_na25od33, tt_rfjvar, tt_rfmos_25, tt_rtmom, tt_na25od33, tt_dio_na25, tt_rfres_rpo, tt_hvt, tt_rfind, tt_rfmvar_25, tt_na25, tt_lvt]
  Variables: frf2 = 0; prf2 = 0; VBB = 650m; VLO = 700m; Wrf = 1u; frf = 0; L = 150p; Llo = 65n; Lrf = 65n; nflo = 62; nfrf = 40; pacmag = 1; plo = 10; C = 0; flo = 26G; prf = -30; RL = 404; VDD = 1.2; Wlo = 1u
  Temperature: 27
  Analysis pss: engine=Shooting fund=26G harms=10
  Analysis pac: start=400M stop=28G fund=26G sweeptype=absolute
  Output ((/net02 /net2))/((/net18 /net16) h=0) pac dB20(V/V) = db(((vh('pac "/net02") - vh('pac "/net2")) / harmonic((vh('pac "/net18") - vh('pac "/net16")) '(0)))) (unticked)
  Output ((/net2 /net02))/((/net18 /net16) h=0)  pss dB20(V/V) = db(((vh('pss "/net2") - vh('pss "/net02")) / harmonic((vh('pss "/net18") - vh('pss "/net16")) '(0))))
Test qpss: PROJECT_MIXER/tb_real/schematic, simulator spectre
  Models: /home/work/RF_26/TSMC65GP_22/tsmcN65/../models/spectre/crn65gplus_2d5_lk_v1d0.scs[tt_bip, tt_dio, tt_dio_33, tt_mim, tt_dio_dnw, tt_dio_18, tt_bip_npn, tt_33, tt_rfrtmom, tt_mos_cap_25, tt_18, tt_disres, tt_res, tt_dio_na, tt_rfmos_33, tt_dio_hvt, tt_rfmvar, tt_rfmos_18, tt_na, tt_dio_na33, tt_dio_lvt, tt_rfres_sa, tt_na33, tt_dio_esd, tt_rfmim, tt_dio_25od33, tt_25od33, tt, tt_mos_cap, tt_dio_25, tt_dio_25ud18, tt_25, tt_rfmos, tt_25ud18, tt_dio_na25od33, tt_rfjvar, tt_rfmos_25, tt_rtmom, tt_na25od33, tt_dio_na25, tt_rfres_rpo, tt_hvt, tt_rfind, tt_rfmvar_25, tt_na25, tt_lvt]
  Variables: flo = 26G; frf = 400M; VDD = 1.2; VLO = 800m; Wlo = 1u; Wrf = 1u; Llo = 65n; Lrf = 65n; nflo = 62; nfrf = 40; pacmag = 1; plo = 10; prf = -30; VBB = 650m
  Temperature: 27
  Analysis qpss: sweep frf start=100M stop=700M lin=10 engine=Shooting funds=("FLO" "RF") maxharms=("7" "3")
  Output ((/net02 /net2) h=1,1)/((/net16 /net18) h=0,1) qpss dB20(V/V) = db(((vh('qpss "/net02" '((1 1))) - vh('qpss "/net2" '((1 1)))) / (vh('qpss "/net16" '((0 1))) - vh('qpss "/net18" '((0 1))))))
Test noise: PROJECT_MIXER/tb_real/schematic, simulator spectre
  Models: /home/work/RF_26/TSMC65GP_22/tsmcN65/../models/spectre/crn65gplus_2d5_lk_v1d0.scs[tt_bip, tt_dio, tt_dio_33, tt_mim, tt_dio_dnw, tt_dio_18, tt_bip_npn, tt_33, tt_rfrtmom, tt_mos_cap_25, tt_18, tt_disres, tt_res, tt_dio_na, tt_rfmos_33, tt_dio_hvt, tt_rfmvar, tt_rfmos_18, tt_na, tt_dio_na33, tt_dio_lvt, tt_rfres_sa, tt_na33, tt_dio_esd, tt_rfmim, tt_dio_25od33, tt_25od33, tt, tt_mos_cap, tt_dio_25, tt_dio_25ud18, tt_25, tt_rfmos, tt_25ud18, tt_dio_na25od33, tt_rfjvar, tt_rfmos_25, tt_rtmom, tt_na25od33, tt_dio_na25, tt_rfres_rpo, tt_hvt, tt_rfind, tt_rfmvar_25, tt_na25, tt_lvt]
  Variables: flo = 26G; frf = 400M; Llo = 65n; Lrf = 65n; nflo = 62; nfrf = 40; pacmag = 1; plo = 10; prf = -30; VBB = 650m; VDD = 1.2; VLO = 800m; Wlo = 1u; Wrf = 1u
  Temperature: 27
  Analysis qpss: engine=Shooting funds=("FLO" "RF") maxharms=("7" "3")
  Analysis qpnoise: start=26G stop=27G oprobe=/PORT5 iprobe=/PORT1 refsideband=("-1" "0")
  Output noise figure = getData("NF" ?result "qpnoise")
Test IIP1dB: PROJECT_MIXER/tb_real/schematic, simulator spectre
  Models: /home/work/RF_26/TSMC65GP_22/tsmcN65/../models/spectre/crn65gplus_2d5_lk_v1d0.scs[tt_bip, tt_dio, tt_dio_33, tt_mim, tt_dio_dnw, tt_dio_18, tt_bip_npn, tt_33, tt_rfrtmom, tt_mos_cap_25, tt_18, tt_disres, tt_res, tt_dio_na, tt_rfmos_33, tt_dio_hvt, tt_rfmvar, tt_rfmos_18, tt_na, tt_dio_na33, tt_dio_lvt, tt_rfres_sa, tt_na33, tt_dio_esd, tt_rfmim, tt_dio_25od33, tt_25od33, tt, tt_mos_cap, tt_dio_25, tt_dio_25ud18, tt_25, tt_rfmos, tt_25ud18, tt_dio_na25od33, tt_rfjvar, tt_rfmos_25, tt_rtmom, tt_na25od33, tt_dio_na25, tt_rfres_rpo, tt_hvt, tt_rfind, tt_rfmvar_25, tt_na25, tt_lvt]
  Variables: flo = 26G; frf = 400M; pacmag = 1; plo = 10; prf = -30; VBB = 650m; VDD = 1.2; VLO = 800m; Wlo = 1u; Wrf = 1u; Llo = 65n; Lrf = 65n; nflo = 62; nfrf = 40
  Temperature: 27
  Analysis qpss: sweep prf start=-30 stop=10 sweepStep=1 engine=Shooting funds=("FLO" "RF") maxharms=("7" "7")
  Output compressionCurves = compressionVRICurves((v("/net2" ?result "qpss_fi") - v("/net02" ?result "qpss_fi")) '(1 1) ?rport resultParam("PORT5:r" ?result "qpss_fi") ?gcomp 1)
  Output Input Referred 1dB Compression Point = compressionVRI((v("/net2" ?result "qpss_fi") - v("/net02" ?result "qpss_fi")) '(1 1) ?rport resultParam("PORT5:r" ?result "qpss_fi") ?gcomp 1)
  Output 1st Order freq = "cadar(setof(x harmonicFreqList(?result \"qpss_fi\") equal(car(x) '(1 1))))" (unticked)
Test IIP3: PROJECT_MIXER/tb_real/schematic, simulator spectre
  Models: /home/work/RF_26/TSMC65GP_22/tsmcN65/../models/spectre/crn65gplus_2d5_lk_v1d0.scs[tt_bip, tt_dio, tt_dio_33, tt_mim, tt_dio_dnw, tt_dio_18, tt_bip_npn, tt_33, tt_rfrtmom, tt_mos_cap_25, tt_18, tt_disres, tt_res, tt_dio_na, tt_rfmos_33, tt_dio_hvt, tt_rfmvar, tt_rfmos_18, tt_na, tt_dio_na33, tt_dio_lvt, tt_rfres_sa, tt_na33, tt_dio_esd, tt_rfmim, tt_dio_25od33, tt_25od33, tt, tt_mos_cap, tt_dio_25, tt_dio_25ud18, tt_25, tt_rfmos, tt_25ud18, tt_dio_na25od33, tt_rfjvar, tt_rfmos_25, tt_rtmom, tt_na25od33, tt_dio_na25, tt_rfres_rpo, tt_hvt, tt_rfind, tt_rfmvar_25, tt_na25, tt_lvt]
  Variables: frf2 = 401M; prf2 = -40; VDD = 1.2; VLO = 800m; Wlo = 1u; Wrf = 1u; flo = 26G; frf = 400M; Llo = 65n; Lrf = 65n; nflo = 62; nfrf = 40; pacmag = 1; plo = 10; prf = -40; VBB = 650m
  Temperature: 27
  Analysis qpss: engine=Shooting funds=("FLO" "RF" "RF2") maxharms=("7" "3" "3")
  Output ipnCurves = ipnVRICurves((v("/net2" ?result "qpss_fi") - v("/net02" ?result "qpss_fi")) '(1 -2 1) '(1 0 1) ?rport resultParam("PORT5:r" ?result "qpss_fi") ?epoint -30) (unticked)
  Output Input Referred IP3 Point = ipnVRI((v("/net2" ?result "qpss_fi") - v("/net02" ?result "qpss_fi")) '(1 -2 1) '(1 0 1) ?rport resultParam("PORT5:r" ?result "qpss_fi") ?epoint -30) (unticked)
  Output 1st Order freq = "cadar(setof(x harmonicFreqList(?result \"qpss_fi\") equal(car(x) '(1 0 1))))" (unticked)
Test dc: PROJECT_MIXER/tb_ideal/schematic, simulator spectre
  Models: /home/work/RF_26/TSMC65GP_22/tsmcN65/../models/spectre/crn65gplus_2d5_lk_v1d0.scs[tt_bip, tt_dio, tt_dio_33, tt_mim, tt_dio_dnw, tt_dio_18, tt_bip_npn, tt_33, tt_rfrtmom, tt_mos_cap_25, tt_18, tt_disres, tt_res, tt_dio_na, tt_rfmos_33, tt_dio_hvt, tt_rfmvar, tt_rfmos_18, tt_na, tt_dio_na33, tt_dio_lvt, tt_rfres_sa, tt_na33, tt_dio_esd, tt_rfmim, tt_dio_25od33, tt_25od33, tt, tt_mos_cap, tt_dio_25, tt_dio_25ud18, tt_25, tt_rfmos, tt_25ud18, tt_dio_na25od33, tt_rfjvar, tt_rfmos_25, tt_rtmom, tt_na25od33, tt_dio_na25, tt_rfres_rpo, tt_hvt, tt_rfind, tt_rfmvar_25, tt_na25, tt_lvt]
  Variables: VBB = 488m; VLO = 854m; pacmag = 1; plo = 10; C = 0; flo = 26G; prf = -30; RL = 404; VDD = 1.2; Wlo = 1u; Wrf = 1u; L = 150p; Llo = 65n; Lrf = 70n; nflo = 62; frf = 400M; nfrf = 60
  Temperature: 27
  Analysis dc: sweep VBB start=0 stop=1.2 (saves the operating point)
  Output RF_I = OS("/I21/NMOS_RF" "ids")
  Output RF_JD = (OS("/I21/NMOS_RF" "ids") / (VAR("Wrf") * VAR("nfrf"))) (unticked)
  Output CddRF = OS("/I21/NMOS_RF" "cdd") (unticked)
  Output CddLO = OS("/I21/NMOS_LO" "cdd") (unticked)
  Output (VDC("/net02") / VDC("/net10"))
  Output (VDC("/net02") / VDC("/net18"))
  Output RF_VGS = OS("/I21/NMOS_RF" "vgs") (unticked)
  Output RF_REG = OS("/I21/NMOS_RF" "region") (unticked)
  Output RF_GM = OS("/I21/NMOS_RF" "gm")
  Output RF_VDS = OS("/I21/NMOS_RF" "vds") (unticked)
  Output LO_I = OS("/I21/NMOS_LO" "ids") (unticked)
  Output LO_JD = (OS("/I21/NMOS_LO" "ids") / (VAR("Wlo") * VAR("nflo")))
  Output LO_VGS = OS("/I21/NMOS_LO" "vgs") (unticked)
  Output LO_REG = OS("/I21/NMOS_LO" "region") (unticked)
  Output LO_GM = OS("/I21/NMOS_LO" "gm") (unticked)
  Output LO_VDS = OS("/I21/NMOS_LO" "vds") (unticked)
Test tran: PROJECT_MIXER/tb_real/schematic, simulator spectre
  Models: /home/work/RF_26/TSMC65GP_22/tsmcN65/../models/spectre/crn65gplus_2d5_lk_v1d0.scs[tt_bip, tt_dio, tt_dio_33, tt_mim, tt_dio_dnw, tt_dio_18, tt_bip_npn, tt_33, tt_rfrtmom, tt_mos_cap_25, tt_18, tt_disres, tt_res, tt_dio_na, tt_rfmos_33, tt_dio_hvt, tt_rfmvar, tt_rfmos_18, tt_na, tt_dio_na33, tt_dio_lvt, tt_rfres_sa, tt_na33, tt_dio_esd, tt_rfmim, tt_dio_25od33, tt_25od33, tt, tt_mos_cap, tt_dio_25, tt_dio_25ud18, tt_25, tt_rfmos, tt_25ud18, tt_dio_na25od33, tt_rfjvar, tt_rfmos_25, tt_rtmom, tt_na25od33, tt_dio_na25, tt_rfres_rpo, tt_hvt, tt_rfind, tt_rfmvar_25, tt_na25, tt_lvt]
  Variables: VBB = 650m; VLO = 700m; RL = 404; VDD = 1.2; Wlo = 1u; Wrf = 1u; frf = 400M; L = 150p; Llo = 65n; Lrf = 65n; nflo = 62; nfrf = 40; C = 0; flo = 26G; pacmag = 1; plo = 10; prf = -30
  Temperature: 27
  Analysis tran: stop=1u errpreset=moderate
  Output VOUT = vtime('tran "/net2")
  Output VBB = vtime('tran "/net10")
  Output LO = vtime('tran "/net8") (unticked)
Run mode: Single Run, Sweeps and Corners

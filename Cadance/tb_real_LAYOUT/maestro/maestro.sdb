ADE simulation setup
Run mode: Single Run, Sweeps and Corners
Tests:
  pss_sweep: PROJECT_MIXER/tb_real_LAYOUT/schematic, simulator spectre
    Variables: frf2 = 0; prf2 = 0; nfrf = 40; pacmag = 1; plo = 10; C = 0; flo = 26G; prf = -30; RL = 404; VDD = 1.2; Wlo = 1u; VBB = 650m; VLO = 700m; Wrf = 1u; frf = 0; L = 150p; Llo = 65n; Lrf = 65n; nflo = 62
  pac: PROJECT_MIXER/tb_real_LAYOUT/schematic, simulator spectre
    Variables: VBB = 650m; VLO = 700m; Wrf = 1u; frf = 0; L = 150p; Llo = 65n; Lrf = 65n; nflo = 62; nfrf = 40; pacmag = 1; plo = 10; C = 0; flo = 26G; prf = -30; RL = 404; VDD = 1.2; Wlo = 1u; frf2 = 0; prf2 = 0
  qpss: PROJECT_MIXER/tb_real/schematic, simulator spectre
    Variables: flo = 26G; frf = 400M; Llo = 65n; Lrf = 65n; nflo = 62; nfrf = 40; pacmag = 1; plo = 10; prf = -30; VBB = 650m; VDD = 1.2; VLO = 800m; Wlo = 1u; Wrf = 1u
  noise: PROJECT_MIXER/tb_real/schematic, simulator spectre
    Variables: flo = 26G; frf = 400M; Llo = 65n; Lrf = 65n; nflo = 62; nfrf = 40; pacmag = 1; plo = 10; prf = -30; VBB = 650m; VDD = 1.2; VLO = 800m; Wlo = 1u; Wrf = 1u
  IIP1dB: PROJECT_MIXER/tb_real/schematic, simulator spectre
    Variables: flo = 26G; frf = 400M; Llo = 65n; Lrf = 65n; nflo = 62; nfrf = 40; pacmag = 1; plo = 10; prf = -30; VBB = 650m; VDD = 1.2; VLO = 800m; Wlo = 1u; Wrf = 1u
  IIP3: PROJECT_MIXER/tb_real/schematic, simulator spectre
    Variables: flo = 26G; frf = 400M; Llo = 65n; Lrf = 65n; nflo = 62; nfrf = 40; pacmag = 1; plo = 10; prf = -40; VBB = 650m; VDD = 1.2; VLO = 800m; Wlo = 1u; Wrf = 1u; frf2 = 401M; prf2 = -40
  dc: PROJECT_MIXER/tb_ideal/schematic, simulator spectre
    Variables: flo = 26G; frf = 400M; L = 150p; Llo = 65n; Lrf = 70n; nflo = 62; nfrf = 60; pacmag = 1; plo = 10; prf = -30; RL = 404; VDD = 1.2; Wlo = 1u; Wrf = 1u; C = 0; VBB = 488m; VLO = 854m
    Outputs: OS("/I21/NMOS_RF" "ids"); RF_JD; LO_JD
  tran: PROJECT_MIXER/tb_real/schematic, simulator spectre
    Variables: VBB = 650m; VLO = 700m; Wrf = 1u; frf = 400M; L = 150p; Llo = 65n; Lrf = 65n; nflo = 62; nfrf = 40; C = 0; flo = 26G; pacmag = 1; plo = 10; prf = -30; RL = 404; VDD = 1.2; Wlo = 1u

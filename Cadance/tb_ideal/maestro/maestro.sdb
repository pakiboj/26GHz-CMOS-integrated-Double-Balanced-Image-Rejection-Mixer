ADE simulation setup
Run mode: Single Run, Sweeps and Corners
Tests:
  pac:1: PROJECT_MIXER/tb_ideal/schematic, simulator spectre
    Variables: C = 0; flo = 26G; frf = 0; L = 150p; Llo = 65n; Lrf = 65n; nflo = 62; nfrf = 40; pacmag = 1; plo = 10; prf = -30; RL = 404; VDD = 1.2; Wlo = 1u; Wrf = 1u; VBB = 650m; VLO = 700m
  qpss: PROJECT_MIXER/tb_ideal/schematic, simulator spectre
    Variables: C = 0; flo = 26G; frf = 400M; L = 150p; Llo = 65n; Lrf = 140n; nflo = 62; nfrf = 40; pacmag = 1; plo = 10; prf = -30; RL = 404; VDD = 1.2; Wlo = 1u; Wrf = 1u; VBB = 650m; VLO = 800m
  noise: PROJECT_MIXER/tb_ideal/schematic, simulator spectre
    Variables: flo = 5.6G; frf = 5.601G; pacmag = 1; plo = 10; prf = -30
  IIP1dB: PROJECT_MIXER/tb_ideal/schematic, simulator spectre
    Variables: flo = 5.6G; frf = 5.601G; pacmag = 1; plo = 10; prf = -30
  S: PROJECT_MIXER/tb_ideal/schematic, simulator spectre
    Variables: flo = 26G; frf = 400M; pacmag = 1; plo = 10; prf = -30; L = 150p; Llo = 65n; Lrf = 65n; nflo = 60; nfrf = 24; RL = 400; VDD = 1.2; Wlo = 1u; Wrf = 1u; C = 0; VBB = 650m; VLO = 700m
  dc: PROJECT_MIXER/tb_ideal/schematic, simulator spectre
    Variables: flo = 26G; frf = 400M; L = 150p; Llo = 65n; Lrf = 70n; nflo = 62; nfrf = 60; pacmag = 1; plo = 10; prf = -30; RL = 404; VDD = 1.2; Wlo = 1u; Wrf = 1u; C = 0; VBB = 488m; VLO = 854m
    Outputs: OS("/I21/NMOS_RF" "ids"); RF_JD; LO_JD
  tran: PROJECT_MIXER/tb_ideal/schematic, simulator spectre
    Variables: flo = 26G; frf = 400M; L = 150p; Llo = 65n; Lrf = 65n; nflo = 62; nfrf = 40; pacmag = 1; plo = 10; prf = -30; RL = 404; VDD = 1.2; Wlo = 1u; Wrf = 1u; C = 0; VBB = 650m; VLO = 700m

ADE simulation setup
Test pac:1: PROJECT_MIXER/tb_ideal/schematic, simulator spectre
  Models: /home/work/RF_26/TSMC65GP_22/tsmcN65/../models/spectre/crn65gplus_2d5_lk_v1d0.scs[tt_bip, tt_dio, tt_dio_33, tt_mim, tt_dio_dnw, tt_dio_18, tt_bip_npn, tt_33, tt_rfrtmom, tt_mos_cap_25, tt_18, tt_disres, tt_res, tt_dio_na, tt_rfmos_33, tt_dio_hvt, tt_rfmvar, tt_rfmos_18, tt_na, tt_dio_na33, tt_dio_lvt, tt_rfres_sa, tt_na33, tt_dio_esd, tt_rfmim, tt_dio_25od33, tt_25od33, tt, tt_mos_cap, tt_dio_25, tt_dio_25ud18, tt_25, tt_rfmos, tt_25ud18, tt_dio_na25od33, tt_rfjvar, tt_rfmos_25, tt_rtmom, tt_na25od33, tt_dio_na25, tt_rfres_rpo, tt_hvt, tt_rfind, tt_rfmvar_25, tt_na25, tt_lvt]
  Variables: VBB = 650m; VLO = 700m; Llo = 65n; Lrf = 65n; nflo = 62; nfrf = 40; pacmag = 1; plo = 10; C = 0; flo = 26G; prf = -30; RL = 404; VDD = 1.2; Wlo = 1u; Wrf = 1u; frf = 0; L = 150p
  Temperature: 27
  Analysis pac: start=400M stop=28G fund=26G sweeptype=absolute
  Analysis pss: engine=Shooting fund=26G harms=10
  Output ((/net02 /net2))/((/net18 /net16) h=0) pac dB20(V/V) = db(((vh('pac "/net02") - vh('pac "/net2")) / harmonic((vh('pac "/net18") - vh('pac "/net16")) '(0))))
Test qpss: PROJECT_MIXER/tb_ideal/schematic, simulator spectre
  Models: /home/work/RF_26/TSMC65GP_22/tsmcN65/../models/spectre/crn65gplus_2d5_lk_v1d0.scs[tt_bip, tt_dio, tt_dio_33, tt_mim, tt_dio_dnw, tt_dio_18, tt_bip_npn, tt_33, tt_rfrtmom, tt_mos_cap_25, tt_18, tt_disres, tt_res, tt_dio_na, tt_rfmos_33, tt_dio_hvt, tt_rfmvar, tt_rfmos_18, tt_na, tt_dio_na33, tt_dio_lvt, tt_rfres_sa, tt_na33, tt_dio_esd, tt_rfmim, tt_dio_25od33, tt_25od33, tt, tt_mos_cap, tt_dio_25, tt_dio_25ud18, tt_25, tt_rfmos, tt_25ud18, tt_dio_na25od33, tt_rfjvar, tt_rfmos_25, tt_rtmom, tt_na25od33, tt_dio_na25, tt_rfres_rpo, tt_hvt, tt_rfind, tt_rfmvar_25, tt_na25, tt_lvt]
  Variables: VBB = 650m; VLO = 800m; C = 0; flo = 26G; L = 150p; Llo = 65n; Lrf = 140n; nflo = 62; nfrf = 40; pacmag = 1; plo = 10; prf = -30; RL = 404; VDD = 1.2; Wlo = 1u; Wrf = 1u; frf = 400M
  Temperature: 27
  Analysis qpss: sweep frf start=5.60000001G stop=5.8G lin=100 engine=Shooting funds=("FLO" "RF") maxharms=("7" "3")
  Output ((/net2 /net3) h=-1,1)/((/net5 /gnd!) h=0,1) qpss dB20(V/V) = db(((vh('qpss "/net2" '((-1 1))) - vh('qpss "/net3" '((-1 1)))) / vh('qpss "/net5" '((0 1)))))
Test noise: PROJECT_MIXER/tb_ideal/schematic, simulator spectre
  Models: /home/work/RF_26/TSMC65GP_22/tsmcN65/../models/spectre/crn65gplus_2d5_lk_v1d0.scs[tt_bip, tt_dio, tt_dio_33, tt_mim, tt_dio_dnw, tt_dio_18, tt_bip_npn, tt_33, tt_rfrtmom, tt_mos_cap_25, tt_18, tt_disres, tt_res, tt_dio_na, tt_rfmos_33, tt_dio_hvt, tt_rfmvar, tt_rfmos_18, tt_na, tt_dio_na33, tt_dio_lvt, tt_rfres_sa, tt_na33, tt_dio_esd, tt_rfmim, tt_dio_25od33, tt_25od33, tt, tt_mos_cap, tt_dio_25, tt_dio_25ud18, tt_25, tt_rfmos, tt_25ud18, tt_dio_na25od33, tt_rfjvar, tt_rfmos_25, tt_rtmom, tt_na25od33, tt_dio_na25, tt_rfres_rpo, tt_hvt, tt_rfind, tt_rfmvar_25, tt_na25, tt_lvt]
  Variables: flo = 5.6G; frf = 5.601G; pacmag = 1; plo = 10; prf = -30
  Temperature: 27
  Analysis qpss: engine=Shooting funds=("FLO" "RF") maxharms=("7" "3")
  Analysis qpnoise: start=1M stop=10M oprobe=/PORT2 iprobe=/PORT0 sweeptype=absolute refsideband=("1" "0")
  Output noise figure = getData("NF" ?result "qpnoise")
  Output output noise; V / sqrt(Hz) = harmonic(sqrt(getData("out" ?result "qpnoise_xfersrc")) '((-7 -3) (-7 -2) (-7 -1) (-7 0) (-7 1) (-7 2) (-7 3) (-6 -3) (-6 -2) (-6 -1) (-6 0) (-6 1) (-6 2) (-6 3) (-5 -3) (-5 -2) (-5 -1) (-5 0) (-5 1) (-5 2) (-5 3) (-4 -3) (-4 -2) (-4 -1) (-4 0) (-4 1) (-4 2) (-4 3) (-3 -3) (-3 -2) (-3 -1) (-3 0) (-3 1) (-3 2) (-3 3) (-2 -3) (-2 -2) (-2 -1) (-2 0) (-2 1) (-2 2) (-2 3) (-1 -3) (-1 -2) (-1 -1) (-1 0) (-1 1) (-1 2) (-1 3) (0 -3) (0 -2) (0 -1) (0 0) (0 1) (0 2) (0 3) (1 -3) (1 -2) (1 -1) (1 0) (1 1) (1 2) (1 3) (2 -3) (2 -2) (2 -1) (2 0) (2 1) (2 2) (2 3) (3 -3) (3 -2) (3 -1) (3 0) (3 1) (3 2) (3 3) (4 -3) (4 -2) (4 -1) (4 0) (4 1) (4 2) (4 3) (5 -3) (5 -2) (5 -1) (5 0) (5 1) (5 2) (5 3) (6 -3) (6 -2) (6 -1) (6 0) (6 1) (6 2) (6 3) (7 -3) (7 -2) (7 -1) (7 0) (7 1) (7 2) (7 3)))
Test IIP1dB: PROJECT_MIXER/tb_ideal/schematic, simulator spectre
  Models: /home/work/RF_26/TSMC65GP_22/tsmcN65/../models/spectre/crn65gplus_2d5_lk_v1d0.scs[tt_bip, tt_dio, tt_dio_33, tt_mim, tt_dio_dnw, tt_dio_18, tt_bip_npn, tt_33, tt_rfrtmom, tt_mos_cap_25, tt_18, tt_disres, tt_res, tt_dio_na, tt_rfmos_33, tt_dio_hvt, tt_rfmvar, tt_rfmos_18, tt_na, tt_dio_na33, tt_dio_lvt, tt_rfres_sa, tt_na33, tt_dio_esd, tt_rfmim, tt_dio_25od33, tt_25od33, tt, tt_mos_cap, tt_dio_25, tt_dio_25ud18, tt_25, tt_rfmos, tt_25ud18, tt_dio_na25od33, tt_rfjvar, tt_rfmos_25, tt_rtmom, tt_na25od33, tt_dio_na25, tt_rfres_rpo, tt_hvt, tt_rfind, tt_rfmvar_25, tt_na25, tt_lvt]
  Variables: flo = 5.6G; frf = 5.601G; pacmag = 1; plo = 10; prf = -30
  Temperature: 27
  Analysis qpss: sweep prf start=-30 stop=10 sweepStep=1 engine=Shooting funds=("FLO" "RF") maxharms=("7" "3")
  Output compressionCurves = compressionVRICurves((v("/net2" ?result "qpss_fi") - v("/net3" ?result "qpss_fi")) '(-1 1) ?rport resultParam("Error:r" ?result "qpss_fi") ?gcomp 1)
  Output Input Referred 1dB Compression Point = compressionVRI((v("/net2" ?result "qpss_fi") - v("/net3" ?result "qpss_fi")) '(-1 1) ?rport resultParam("Error:r" ?result "qpss_fi") ?gcomp 1)
  Output 1st Order freq = "cadar(setof(x harmonicFreqList(?result \"qpss_fi\") equal(car(x) '(-1 1))))" (unticked)
Test S: PROJECT_MIXER/tb_ideal/schematic, simulator spectre
  Models: /home/work/RF_26/TSMC65GP_22/tsmcN65/../models/spectre/crn65gplus_2d5_lk_v1d0.scs[tt_bip, tt_dio, tt_dio_33, tt_mim, tt_dio_dnw, tt_dio_18, tt_bip_npn, tt_33, tt_rfrtmom, tt_mos_cap_25, tt_18, tt_disres, tt_res, tt_dio_na, tt_rfmos_33, tt_dio_hvt, tt_rfmvar, tt_rfmos_18, tt_na, tt_dio_na33, tt_dio_lvt, tt_rfres_sa, tt_na33, tt_dio_esd, tt_rfmim, tt_dio_25od33, tt_25od33, tt, tt_mos_cap, tt_dio_25, tt_dio_25ud18, tt_25, tt_rfmos, tt_25ud18, tt_dio_na25od33, tt_rfjvar, tt_rfmos_25, tt_rtmom, tt_na25od33, tt_dio_na25, tt_rfres_rpo, tt_hvt, tt_rfind, tt_rfmvar_25, tt_na25, tt_lvt]
  Variables: VBB = 650m; VLO = 700m; Wrf = 1u; flo = 26G; frf = 400M; pacmag = 1; plo = 10; prf = -30; Llo = 65n; C = 0; L = 150p; Lrf = 65n; nflo = 60; nfrf = 24; RL = 400; VDD = 1.2; Wlo = 1u
  Temperature: 27
  Analysis psp: start=1M stop=30G ports=[/PORT5]
  Analysis pss: engine=Shooting fund=26G harms=8
  Output Z11 magOhm = zpm('psp 1 1) (unticked)
  Output Real Z = real(zpm('psp 1 1))
  Output Imag Z = (imag(zpm('psp 1 1)) / (2 * pi * xval(zpm('psp 1 1)))) (unticked)
  Output Y11 magS = ypm('psp 1 1) (unticked)
  Output Imag Y = (imag(ypm('psp 1 1)) / (2 * pi * xval(zpm('psp 1 1))))
Test dc: PROJECT_MIXER/tb_ideal/schematic, simulator spectre
  Models: /home/work/RF_26/TSMC65GP_22/tsmcN65/../models/spectre/crn65gplus_2d5_lk_v1d0.scs[tt_bip, tt_dio, tt_dio_33, tt_mim, tt_dio_dnw, tt_dio_18, tt_bip_npn, tt_33, tt_rfrtmom, tt_mos_cap_25, tt_18, tt_disres, tt_res, tt_dio_na, tt_rfmos_33, tt_dio_hvt, tt_rfmvar, tt_rfmos_18, tt_na, tt_dio_na33, tt_dio_lvt, tt_rfres_sa, tt_na33, tt_dio_esd, tt_rfmim, tt_dio_25od33, tt_25od33, tt, tt_mos_cap, tt_dio_25, tt_dio_25ud18, tt_25, tt_rfmos, tt_25ud18, tt_dio_na25od33, tt_rfjvar, tt_rfmos_25, tt_rtmom, tt_na25od33, tt_dio_na25, tt_rfres_rpo, tt_hvt, tt_rfind, tt_rfmvar_25, tt_na25, tt_lvt]
  Variables: VBB = 488m; VLO = 854m; flo = 26G; prf = -30; RL = 404; VDD = 1.2; Wlo = 1u; Wrf = 1u; L = 150p; Llo = 65n; Lrf = 70n; nflo = 62; frf = 400M; nfrf = 60; pacmag = 1; plo = 10; C = 0
  Temperature: 27
  Analysis dc: sweep VBB start=0 stop=1.2 (saves the operating point)
  Output RF_I = OS("/I21/NMOS_RF" "ids")
  Output RF_JD = (OS("/I21/NMOS_RF" "ids") / (VAR("Wrf") * VAR("nfrf"))) (unticked)
  Output LO_GM = OS("/I21/NMOS_LO" "gm") (unticked)
  Output LO_VDS = OS("/I21/NMOS_LO" "vds") (unticked)
  Output CddRF = OS("/I21/NMOS_RF" "cdd") (unticked)
  Output CddLO = OS("/I21/NMOS_LO" "cdd") (unticked)
  Output (VDC("/net02") / VDC("/net10"))
  Output (VDC("/net02") / VDC("/net18"))
  Output RF_VGS = OS("/I21/NMOS_RF" "vgs") (unticked)
  Output RF_REG = OS("/I21/NMOS_RF" "region") (unticked)
  Output RF_GM = OS("/I21/NMOS_RF" "gm")
  Output RF_VDS = OS("/I21/NMOS_RF" "vds") (unticked)
  Output LO_I = OS("/I21/NMOS_LO" "ids") (unticked)
  Output LO_JD = (OS("/I21/NMOS_LO" "ids") / (VAR("Wlo") * VAR("nflo")))
  Output LO_VGS = OS("/I21/NMOS_LO" "vgs") (unticked)
  Output LO_REG = OS("/I21/NMOS_LO" "region") (unticked)
Test tran: PROJECT_MIXER/tb_ideal/schematic, simulator spectre
  Models: /home/work/RF_26/TSMC65GP_22/tsmcN65/../models/spectre/crn65gplus_2d5_lk_v1d0.scs[tt_bip, tt_dio, tt_dio_33, tt_mim, tt_dio_dnw, tt_dio_18, tt_bip_npn, tt_33, tt_rfrtmom, tt_mos_cap_25, tt_18, tt_disres, tt_res, tt_dio_na, tt_rfmos_33, tt_dio_hvt, tt_rfmvar, tt_rfmos_18, tt_na, tt_dio_na33, tt_dio_lvt, tt_rfres_sa, tt_na33, tt_dio_esd, tt_rfmim, tt_dio_25od33, tt_25od33, tt, tt_mos_cap, tt_dio_25, tt_dio_25ud18, tt_25, tt_rfmos, tt_25ud18, tt_dio_na25od33, tt_rfjvar, tt_rfmos_25, tt_rtmom, tt_na25od33, tt_dio_na25, tt_rfres_rpo, tt_hvt, tt_rfind, tt_rfmvar_25, tt_na25, tt_lvt]
  Variables: VBB = 650m; VLO = 700m; Wrf = 1u; frf = 400M; L = 150p; Llo = 65n; Lrf = 65n; nflo = 62; nfrf = 40; C = 0; flo = 26G; pacmag = 1; plo = 10; prf = -30; RL = 404; VDD = 1.2; Wlo = 1u
  Temperature: 27
  Analysis tran: stop=1u errpreset=moderate
  Output VOUT = vtime('tran "/net2")
  Output VBB = vtime('tran "/net10")
  Output LO = vtime('tran "/net8") (unticked)
Run mode: Single Run, Sweeps and Corners
